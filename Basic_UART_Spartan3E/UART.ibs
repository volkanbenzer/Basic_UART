| / 7\'7
| \ \   Xilinx Inc.
| / /
| \_\/.\   IBIS Models for Spartan-3E
[IBIS ver]   3.2
[File name]   UART.ibs
[File Rev]   1.5
[Date]   Sat May 31 00:19:27 2025
[Source]   HSPICE simulations
[Notes]   IBIS models for Spartan-3E
[Disclaimer]
|   The data in this model is derived from SPICE simulations using
|   modeling information extracted from the target process. While
|   a great deal of care has been taken to provide information
|   that is accurate, this model is considered preliminary as it
|   has not been verified by actual silicon measurement. Treat the
|   data in this model as preliminary until actual silicon
|   verification is performed.
|   To accurately model package parasitics, please follow the
|   instructions at:  http://www.xilinx.com/xlnx/
|   xil_ans_display.jsp?getPagePath=11754
|   LVDS and LVPECL drivers require the use of external
|   termination resistors to provide the correct voltage levels.
|   For more information, refer to the Spartan-3 documentation.
|   NOTE: This file is compliant with IBIS Version 3.2, but it
|   may not implement all approved 3.2 features.
|   NOTE:  Newer versions of the buffer models may be available.
|   Check the web (http://www.xilinx.com/support/sw_ibis.htm) for
|   the latest file revision.  However, please be aware that the
|   web files are not compatible for use with IBISWriter, and
|   must be manually annotated, should their use be preferred.
[Copyright]
| Copyright 2006, Xilinx Inc., All rights reserved
|   Component Spartan-3E
[Component]   Spartan-3E
[Manufacturer]   Xilinx Inc.
[Package]
| For Package Type fg320
| variable   typ   min   max
R_pkg   279.84m   143.60m   397.60m
L_pkg   5.05nH   2.59nH   7.05nH
C_pkg   0.88pF   0.46pF   1.61pF
[Pin]  signal_name   model_name   R_pin   L_pin   C_pin
F12   rxDataOut_OutputPort<0>   LVTTL_S_8_O
E12   rxDataOut_OutputPort<1>   LVTTL_S_8_O
E11   rxDataOut_OutputPort<2>   LVTTL_S_8_O
F11   rxDataOut_OutputPort<3>   LVTTL_S_8_O
C11   rxDataOut_OutputPort<4>   LVTTL_S_8_O
D11   rxDataOut_OutputPort<5>   LVTTL_S_8_O
E9   rxDataOut_OutputPort<6>   LVTTL_S_8_O
F9   rxDataOut_OutputPort<7>   LVTTL_S_8_O
H13   txDataIn_InputPort<0>   LVTTL_S_12_I
K17   txDataIn_InputPort<1>   LVTTL_S_12_I
D18   txDataIn_InputPort<2>   LVTTL_S_12_I
V4   txDataIn_InputPort<3>   LVTTL_S_12_I
L13   txDataIn_InputPort<4>   LVTTL_S_12_I
C9   clk_InputPin   LVCMOS33_S_12_I
L14   txDataIn_InputPort<5>   LVTTL_S_12_I
H18   txDataIn_InputPort<6>   LVTTL_S_12_I
N17   txDataIn_InputPort<7>   LVTTL_S_12_I
R7   rx_InputPin   LVTTL_S_12_I
B16   reset_InputPin   LVCMOS25_S_12_I
V16   txWrEn_InputPin   LVTTL_S_12_I
M14   tx_OutputPin   LVTTL_S_8_O
B1   PROG_B   LVCMOS25_S_12
C1   IO_L01P_3   NC
C2   IO_L01N_3   NC
D1   IO_L02P_3   NC
D2   IO_L02N_3/VREF_3   NC
D3   IP   NC
E2   IO_L03P_3   NC
E1   IO_L03N_3   NC
F4   IO   NC
F5   IP   NC
F1   IO_L05P_3   NC
F2   IO_L05N_3   NC
G3   IO_L06P_3   NC
G4   IO_L06N_3/VREF_3   NC
G1   IP   NC
G6   IO_L07P_3   NC
G5   IO_L07N_3   NC
H6   IO_L08P_3   NC
H5   IO_L08N_3   NC
J7   IP   NC
H4   IO_L09P_3   NC
H3   IO_L09N_3   NC
H2   IO_L10P_3   NC
H1   IO_L10N_3   NC
J6   IP/VREF_3   NC
J5   LHCLK0   NC
J4   LHCLK1   NC
J1   LHCLK2   NC
J2   LHCLK3/IRDY2   NC
K2   IP   NC
K3   LHCLK4/TRDY2   NC
K4   LHCLK5   NC
K6   LHCLK6   NC
K5   LHCLK7   NC
K7   IP   NC
L1   IO_L15P_3   NC
L2   IO_L15N_3   NC
L3   IO_L16P_3   NC
L4   IO_L16N_3   NC
M1   IP   NC
L6   IO_L17P_3   NC
L5   IO_L17N_3/VREF_3   NC
M4   IO_L18P_3   NC
M3   IO_L18N_3   NC
N1   IP   NC
M5   IO_L19P_3   NC
M6   IO_L19N_3   NC
N4   IO_L20P_3   NC
N5   IO_L20N_3   NC
N2   IP   NC
P2   IO_L21P_3   NC
P1   IO_L21N_3   NC
R4   IO/VREF_3   NC
R1   IP   NC
R3   IO_L23P_3   NC
R2   IO_L23N_3   NC
T2   IO_L24P_3   NC
T1   IO_L24N_3   NC
U1   IP   NC
V2   IP   NC
U3   CSO_B   LVCMOS25_S_12
T3   INIT_B   LVCMOS25_S_12
V3   IP_L02N_2   NC
U4   DOUT/BUSY   NC
T4   MOSI/CSI_B   LVCMOS25_S_12
U5   IO/VREF_2   NC
R5   IO_L04P_2   NC
T5   IO_L04N_2   NC
R6   IO_L05P_2   NC
P6   IO_L05N_2   NC
U6   IP   NC
N7   IO_L07P_2   NC
P7   IO_L07N_2   NC
T7   IP_L08P_2   NC
P8   IO_L09P_2   NC
N8   IO_L09N_2   NC
P9   IO   NC
R8   IO_L10P_2   NC
T8   IO_L10N_2   NC
U8   IP_L11P_2   NC
V8   IP_L11N_2/VREF_2   NC
N9   D7/GCLK12   LVCMOS25_S_12
M9   D6/GCLK13   LVCMOS25_S_12
R9   D5   LVCMOS25_S_12
U9   D4/GCLK14   LVCMOS25_S_12
V9   D3/GCLK15   LVCMOS25_S_12
U10   RDWR_B/GCLK0   LVCMOS25_S_12
T10   M2/GCLK1   LVCMOS25_S_12
R10   D2/GCLK2   LVCMOS25_S_12
P10   D1/GCLK3   LVCMOS25_S_12
V11   M1   LVCMOS25_S_12
M10   M0   LVCMOS25_S_12
N10   DIN/D0   LVCMOS25_S_12
T11   IP_L17P_2   NC
U11   IP_L17N_2   NC
P11   IO_L18P_2   NC
N11   IO_L18N_2   NC
R11   IO   NC
V12   IO_L19P_2   NC
V13   IO_L19N_2/VREF_2   NC
T12   IO_L20P_2   NC
R12   IO_L20N_2   NC
U13   IP   NC
P13   A23   LVCMOS25_S_12
R13   A22   LVCMOS25_S_12
V14   IP_L23P_2   NC
U14   IP_L23N_2   NC
T14   A21   LVCMOS25_S_12
R14   A20   LVCMOS25_S_12
T15   IO/VREF_2   NC
V15   VS2/A19   NC
U15   VS1/A18   NC
T16   VS0/A17   NC
U16   CCLK   LVCMOS25_S_12
V17   DONE   LVCMOS25_S_12
U18   A16   LVCMOS25_S_12
T17   A15   LVCMOS25_S_12
R18   A14   LVCMOS25_S_12
T18   A13   LVCMOS25_S_12
R17   IP   NC
R15   IO_L03P_1   NC
R16   IO_L03N_1/VREF_1   NC
P15   IO   NC
M13   IO_L05N_1/VREF_1   NC
P17   IO_L06P_1   NC
P18   IO_L06N_1   NC
M15   IO_L07P_1   NC
M16   IO_L07N_1   NC
N18   IO_L08P_1   NC
M18   IO_L08N_1   NC
L16   A12   LVCMOS25_S_12
L15   A11   LVCMOS25_S_12
L18   IO_L10P_1   NC
L17   IO_L10N_1/VREF_1   NC
K13   A10/RHCLK0   LVCMOS25_S_12
K12   A9/RHCLK1   LVCMOS25_S_12
K15   A8/RHCLK2   LVCMOS25_S_12
K14   A7/RHCLK3/TRDY1   LVCMOS25_S_12
K18   IP   NC
J17   A6/RHCLK4/IRDY1   LVCMOS25_S_12
J16   A5/RHCLK5   LVCMOS25_S_12
J15   A4/RHCLK6   LVCMOS25_S_12
J14   A3/RHCLK7   LVCMOS25_S_12
J12   A2   LVCMOS25_S_12
J13   A1   LVCMOS25_S_12
H16   IO_L16P_1   NC
H17   A0   LVCMOS25_S_12
G18   IP   NC
H14   IO_L17P_1   NC
H15   IO_L17N_1   NC
G15   IO_L18P_1   NC
G16   IO_L18N_1   NC
F18   IO_L19P_1   NC
F17   IO_L19N_1   NC
G14   IO_L20P_1   NC
G13   IO_L20N_1   NC
E18   IP   NC
F15   IO_L21P_1   NC
F14   IO_L21N_1   NC
E17   IO   NC
D17   HDC   LVCMOS25_S_12
D16   LDC0   LVCMOS25_S_12
C18   LDC1   LVCMOS25_S_12
C17   LDC2   LVCMOS25_S_12
B18   IP   NC
D15   TMS   LVCMOS25_S_12
C16   TDO   LVCMOS25_S_12
A17   TCK   LVCMOS25_S_12
C15   IP   NC
A16   IO_L01N_0   NC
B15   IP_L02P_0   NC
A15   IP_L02N_0   NC
D14   IO_L03P_0   NC
C14   IO_L03N_0/VREF_0   NC
E13   IO   NC
B14   IO_L04P_0   NC
A14   IO_L04N_0   NC
A13   IO_L05P_0   NC
B13   IO_L05N_0/VREF_0   NC
D13   IP   NC
C12   IP_L07P_0   NC
D12   IP_L07N_0   NC
A11   IO   NC
F10   IP_L10P_0   NC
G10   IP_L10N_0   NC
D10   GCLK4   NC
E10   GCLK5   NC
B11   IO/VREF_0   NC
B10   GCLK6   NC
A10   GCLK7   NC
B8   GCLK8   NC
B9   GCLK9   NC
D9   GCLK11   NC
G9   IO   NC
C8   IP_L16P_0   NC
D8   IP_L16N_0   NC
E8   IO_L17P_0   NC
F8   IO_L17N_0   NC
A8   IO   NC
C7   IO_L18P_0   NC
D7   IO_L18N_0/VREF_0   NC
F7   IO_L19P_0   NC
E7   IO_L19N_0/VREF_0   NC
A7   IP   NC
B6   IO_L20P_0   NC
A6   IO_L20N_0   NC
A5   IP_L22P_0   NC
B5   IP_L22N_0   NC
C5   IO_L23P_0   NC
D5   IO_L23N_0/VREF_0   NC
C4   IO   NC
A4   IO_L24P_0   NC
B4   IO_L24N_0   NC
A3   IP   NC
C3   IO_L25P_0   NC
B3   HSWAP   LVCMOS25_S_12
A2   TDI   LVCMOS25_S_12
A1   GND   GND
B2   GND   GND
A18   GND   GND
B17   GND   GND
V1   GND   GND
U2   GND   GND
V18   GND   GND
U17   GND   GND
C10   GND   GND
G7   GND   GND
G12   GND   GND
H8   GND   GND
H9   GND   GND
H10   GND   GND
H11   GND   GND
J8   GND   GND
K8   GND   GND
J11   GND   GND
K11   GND   GND
L8   GND   GND
L9   GND   GND
L10   GND   GND
L11   GND   GND
M7   GND   GND
M12   GND   GND
J3   GND   GND
K16   GND   GND
T9   GND   GND
B7   VCCAUX   POWER
B12   VCCAUX   POWER
G2   VCCAUX   POWER
M2   VCCAUX   POWER
G17   VCCAUX   POWER
M17   VCCAUX   POWER
U7   VCCAUX   POWER
U12   VCCAUX   POWER
A9   VCCO_0   POWER
C6   VCCO_0   POWER
C13   VCCO_0   POWER
G8   VCCO_0   POWER
G11   VCCO_0   POWER
J18   VCCO_1   POWER
F16   VCCO_1   POWER
N16   VCCO_1   POWER
H12   VCCO_1   POWER
L12   VCCO_1   POWER
V10   VCCO_2   POWER
T6   VCCO_2   POWER
T13   VCCO_2   POWER
M8   VCCO_2   POWER
M11   VCCO_2   POWER
K1   VCCO_3   POWER
F3   VCCO_3   POWER
N3   VCCO_3   POWER
H7   VCCO_3   POWER
L7   VCCO_3   POWER
E5   VCCINT   POWER
F6   VCCINT   POWER
E14   VCCINT   POWER
F13   VCCINT   POWER
N6   VCCINT   POWER
P5   VCCINT   POWER
N13   VCCINT   POWER
P14   VCCINT   POWER
| Models and submodels in the file (5): LVCMOS25_S_12 (I/O), LVCMOS25_S_12_I (Input), LVCMOS33_S_12_I (Input), LVTTL_S_12_I (Input), LVTTL_S_8_O (Output)
